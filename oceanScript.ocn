simulator( 'spectre )
design( "/lcars/home/g/gannon1/simulation/12T_DICE_Bitcell_SEU/spectre/schematic/netlist/netlist" )
resultsDir( "/lcars/home/g/gannon1/simulation/12T_DICE_Bitcell_SEU/spectre/schematic" )
modelFile(
    '("/lcars/software/linux/x86_64/ic-design/design_kits/gpdk045_v_6_0/gpdk045/../models/spectre/gpdk045.scs" "tt")
)
analysis( 'tran ?stop "5n" ?step "1p" )
envOption(
    'analysisOrder list("dc" "tran")
)
converge( 'nodeset "/N0" 1.1 )
converge( 'nodeset "/N2" 1.1 )
converge( 'nodeset "/N1" 0.0 )
converge( 'nodeset "/N3" 0.0 )

; ---- Sizing and temperature ----
wn_store_val  = 120e-9
wp_store_val  = 120e-9
wn_access_val = 120e-9
temp_val      = 27.0

desVar( "wn_store"  wn_store_val )
desVar( "wp_store"  wp_store_val )
desVar( "wn_access" wn_access_val )
desVar( "Qinj0" -7e-15 )
desVar( "Qinj1" 0 )
desVar( "Qinj2" "Qinj0" )
desVar( "Qinj3" 0 )
desVar( "Ipeak0" "Qinj0 / 140e-12" )
desVar( "Ipeak1" 0.0 )
desVar( "Ipeak2" "Qinj0 / 140e-12" )
desVar( "Ipeak3" 0.0 )

temp( temp_val )

paramAnalysis( "Qinj0" ?values '(-2e-15 -3e-15 -4e-15 -5e-15 -6e-15 -6.5e-15 -7e-15 -7.25e-15 -7.5e-15 -7.75e-15 -8e-15 -9e-15 -10e-15) )

paramRun()

selectResult( 'tran )

csvport = outfile( "/lcars/home/g/gannon1/simulation/results/dice_seu_results.csv" "a" )

swpVals = sweepValues()

foreach( qval swpVals
    n0_family = getData("/N0")
    n0_wave = value( n0_family "Qinj0" qval )
    flipped = 0
    when( n0_final < 0.55
        flipped = 1
    )
    fprintf( csvport "%g,%g,%g,%g,%g,%d\n"
        wn_store_val wp_store_val wn_access_val temp_val qval flipped )
)

close( csvport )
