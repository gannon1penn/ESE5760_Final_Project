; dice_seu_single.ocn
simulator( 'spectre )
design( "/lcars/home/g/gannon1/simulation/12T_DICE_Bitcell_SEU/spectre/schematic/netlist/netlist" )
resultsDir( "/lcars/home/g/gannon1/simulation/12T_DICE_Bitcell_SEU/spectre/schematic" )
modelFile(
    '("/lcars/software/linux/x86_64/ic-design/design_kits/gpdk045_v_6_0/gpdk045/../models/spectre/gpdk045.scs" "tt")
)
analysis( 'tran ?stop "5n" ?step "1p" )
envOption(
    'analysisOrder list("dc" "tran")
)

; Nodesets are the same for both polarities — cell always stores 1 on N0/N2
converge( 'nodeset "/N0" 1.1 )
converge( 'nodeset "/N2" 1.1 )
converge( 'nodeset "/N1" 0.0 )
converge( 'nodeset "/N3" 0.0 )

desVar( "wn_store"  g_wn_store )
desVar( "wp_store"  g_wp_store )
desVar( "wn_access" g_wn_access )

temp( g_temp )

; ---- Coarse adaptive sweep ----
coarse_list = list( 2e-15 4e-15 6e-15 8e-15 10e-15 11e-15 12e-15 13e-15 16e-15 20e-15 25e-15 30e-15 40e-15 50e-15 )

q_bracket_low  = 0.0
found_bracket  = 0

csvport = outfile( "/lcars/home/g/gannon1/simulation/results/dice_seu_results.csv" "a" )

foreach( qmag coarse_list
    when( found_bracket == 0

        ; ---- Set injection based on polarity ----
        when( g_polarity == 1
            ; Strike N0/N2 (storing 1) with negative current
            desVar( "Qinj0" qmag * -1 )
            desVar( "Qinj2" qmag * -1 )
            desVar( "Ipeak0" qmag * -1 / 140e-12 )
            desVar( "Ipeak2" qmag * -1 / 140e-12 )
            desVar( "Qinj1" 0 )
            desVar( "Qinj3" 0 )
            desVar( "Ipeak1" 0.0 )
            desVar( "Ipeak3" 0.0 )
        )
        when( g_polarity == 0
            ; Strike N1/N3 (storing 0) with positive current
            desVar( "Qinj0" 0 )
            desVar( "Qinj2" 0 )
            desVar( "Ipeak0" 0.0 )
            desVar( "Ipeak2" 0.0 )
            desVar( "Qinj1" qmag )
            desVar( "Qinj3" qmag )
            desVar( "Ipeak1" qmag / 140e-12 )
            desVar( "Ipeak3" qmag / 140e-12 )
        )

        run()
        selectResult( 'tran )

        ; ---- Flip detection ----
        when( g_polarity == 1
            ; N0 starts at 1.1V, flip = drops below 0.55V
            node_val = value( getData("/N0") 5e-9 )
            flipped  = 0
            when( node_val < 0.55
                flipped = 1
            )
        )
        when( g_polarity == 0
            ; N1 starts at 0V, flip = rises above 0.55V
            node_val = value( getData("/N1") 5e-9 )
            flipped  = 0
            when( node_val > 0.55
                flipped = 1
            )
        )

        fprintf( csvport "%g,%g,%g,%g,%d,%g,%d\n"
            g_wn_store g_wp_store g_wn_access g_temp g_polarity qmag flipped )

        when( flipped == 1
            found_bracket = 1
        )
        when( flipped == 0
            q_bracket_low = qmag
        )
    )
)

close( csvport )
