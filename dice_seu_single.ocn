; dice_seu_single.ocn
; Runs a single Qinj sweep for one sizing/temperature condition
; Expects globals: g_wn_store, g_wp_store, g_wn_access, g_temp, g_qinj_list

simulator( 'spectre )
design( "/lcars/home/g/gannon1/simulation/12T_DICE_Bitcell_SEU/spectre/schematic/netlist/netlist" )
resultsDir( "/lcars/home/g/gannon1/simulation/12T_DICE_Bitcell_SEU/spectre/schematic" )
modelFile(
    '("/lcars/software/linux/x86_64/ic-design/design_kits/gpdk045_v_6_0/gpdk045/../models/spectre/gpdk045.scs" "tt")
)
analysis( 'tran ?stop "5n" ?step "1p" )
envOption(
    'analysisOrder list("dc" "tran")
)
converge( 'nodeset "/N0" 1.1 )
converge( 'nodeset "/N2" 1.1 )
converge( 'nodeset "/N1" 0.0 )
converge( 'nodeset "/N3" 0.0 )

desVar( "wn_store"  g_wn_store )
desVar( "wp_store"  g_wp_store )
desVar( "wn_access" g_wn_access )
desVar( "Qinj0" g_qinj )
desVar( "Qinj1" 0 )
desVar( "Qinj2" g_qinj )
desVar( "Qinj3" 0 )
desVar( "Ipeak0" g_qinj / 140e-12 )
desVar( "Ipeak1" 0.0 )
desVar( "Ipeak2" g_qinj / 140e-12 )
desVar( "Ipeak3" 0.0 )

temp( g_temp )

run()
selectResult( 'tran )

n0_final = value( getData("/N0") 5e-9 )
flipped = 0
when( n0_final < 0.55
    flipped = 1
)

csvport = outfile( "/lcars/home/g/gannon1/simulation/results/dice_seu_results.csv" "a" )
fprintf( csvport "%g,%g,%g,%g,%g,%d\n"
    g_wn_store g_wp_store g_wn_access g_temp g_qinj flipped )
close( csvport )
